ADE simulation setup
Run mode: Single Run, Sweeps and Corners
Tests:
  ADC_TB_single_1: ADC/TB_single/schematic, simulator spectre
    Outputs: nil; E5; "/OUT15f"; "/OUT15"; "/OUT05f"; E6; E7; E8; E9; E10; E1; "/OUT07f"; Out07; Out15; Out05; Out04; Out03; Out06; E2; E3; E4; E11; E12; E13; E14; E15
