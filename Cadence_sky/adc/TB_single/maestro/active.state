ADE simulation setup
Test ADC_TB_single_1: ADC/TB_single/schematic, simulator spectre
  Models: /mnt/cae_storage_sw/eda/cadence/pdks/sky130/sky130_release_004a/libs/sky130_fd_pr_main/../../models/sky130.lib.spice[tt]
  Temperature: 27
  Analysis dc: sweep /V1.dc start=0 stop=1.8 lin=500 (saves the operating point)
  Output E1 = xval(intersect(getData("/OUT01f" ?result 'dc) getData("/LL" ?result 'dc))) (unticked)
  Output E2 = xval(intersect(getData("/OUT02f" ?result 'dc) getData("/LL" ?result 'dc))) (unticked)
  Output E3 = xval(intersect(getData("/OUT03f" ?result 'dc) getData("/LL" ?result 'dc)))
  Output E5 = xval(intersect(getData("/OUT05f" ?result 'dc) getData("/LL" ?result 'dc)))
  Output E6 = xval(intersect(getData("/OUT06f" ?result 'dc) getData("/LL" ?result 'dc))) (unticked)
  Output E7 = xval(intersect(getData("/OUT07f" ?result 'dc) getData("/LL" ?result 'dc))) (unticked)
  Output E8 = xval(intersect(getData("/OUT08f" ?result 'dc) getData("/LL" ?result 'dc))) (unticked)
  Output E9 = xval(intersect(getData("/OUT09f" ?result 'dc) getData("/LL" ?result 'dc))) (unticked)
  Output E10 = xval(intersect(getData("/OUT10f" ?result 'dc) getData("/LL" ?result 'dc))) (unticked)
  Output E4 = xval(intersect(getData("/OUT04f" ?result 'dc) getData("/LL" ?result 'dc)))
  Output E11 = xval(intersect(getData("/OUT11f" ?result 'dc) getData("/LL" ?result 'dc))) (unticked)
  Output E12 = xval(intersect(getData("/OUT12f" ?result 'dc) getData("/LL" ?result 'dc))) (unticked)
  Output E13 = xval(intersect(getData("/OUT13f" ?result 'dc) getData("/LL" ?result 'dc))) (unticked)
  Output E14 = xval(intersect(getData("/OUT14f" ?result 'dc) getData("/LL" ?result 'dc))) (unticked)
  Output E15 = xval(intersect(getData("/OUT15f" ?result 'dc) getData("/LL" ?result 'dc))) (unticked)
  Signals: /IN as IN, /LL as LL, /pre_out as Pre_Out, /div_out as Div_Out, /pre_out_cb as Pre_out_cb, /OUT01f as Out01, /OUT02f as Out02, /OUT03f as Out03, /OUT04f as Out04, /OUT05f as Out05, /OUT06f as Out06, /OUT07f as Out07, /OUT08f as Out08, /OUT09f as Out09, /OUT10f as Out10, /OUT11f as Out11, /OUT12f as Out12, /OUT13f as Out13, /OUT14f as Out14, /OUT15f as Out15
