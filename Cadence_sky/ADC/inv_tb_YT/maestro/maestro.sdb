ADE simulation setup
Run mode: Single Run, Sweeps and Corners
Tests:
  ADC_inv_tb_YT_1: ADC/inv_tb_YT/schematic, simulator spectre
