ADE simulation setup
Test ADC_inv_tb_YT_1: ADC/inv_tb_YT/schematic, simulator spectre
  Models: /mnt/cae_storage_sw/eda/cadence/pdks/sky130_release_004a/libs/sky130_fd_pr_main/../../models/sky130.lib.spice[tt]
  Temperature: 27
  Analysis dc: sweep /V1.dc start=0 stop=1.8 lin=50 (saves the operating point)
  Output v /OUT; dc (V) = v("/OUT" ?result "dc")
  Output v /IN; dc (V) = v("/IN" ?result "dc")
Run mode: Single Run, Sweeps and Corners
