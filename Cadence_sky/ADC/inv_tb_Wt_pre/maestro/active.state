ADE simulation setup
Test ADC_inv_tb_Wt_pre_1: ADC/inv_tb_Wt_pre/schematic, simulator spectre
  Models: /mnt/cae_storage_sw/eda/cadence/pdks/sky130_release_004a/libs/sky130_fd_pr_main/../../models/sky130.lib.spice[tt]
  Variables: nL = 150n; nW = 420n; pL = 150n; pW = 550n
  Temperature: 27
  Analysis dc: sweep /V1.dc start=0 stop=1.8 lin=500 (saves the operating point)
  Output E4 = xval(intersect(getData("/OUT" ?result 'dc) getData("/LL" ?result 'dc)))
  Signals: /IN, /OUT, /LL
Run mode: Single Run, Sweeps and Corners
Setup values for test ADC_inv_tb_Wt_pre_1: nL = 150n:150n:1.05u; nW = 420n:150n:1.05u; pL = 150n:150n:1.05u; pW = 550n:150n:1.05u
