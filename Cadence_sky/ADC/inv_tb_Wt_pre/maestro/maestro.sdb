ADE simulation setup
Run mode: Single Run, Sweeps and Corners
Tests:
  ADC_inv_tb_Wt_pre_1: ADC/inv_tb_Wt_pre/schematic, simulator spectre
    Variables: nL = 150n:150n:1.05u; nW = 420n:150n:1.05u; pL = 150n:150n:1.05u; pW = 550n:150n:1.05u
